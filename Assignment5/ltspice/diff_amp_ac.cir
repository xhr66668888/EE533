* Assignment 5 part b - difference amplifier AC check
* This is a quick netlist check. For the submitted schematic, use the ADA4661-2
* symbol in LTspice as explained in LTspice_README.md.

.param R1=25k R2=250k Aol=1e6 GBW=4Meg

VDD   vdd   0     5
Vinp  vip   0     DC 2.5 AC 0.5
Vinm  vim   0     DC 2.5 AC -0.5

* Vref = 2.5 V from divider and unity buffer
Rvtop vdd   vdiv  100k
Rvbot vdiv  0     100k
XBUF  vdiv  vref  vref  OP1P

* Difference amplifier, Vout = Vref + (R2/R1)*(vip-vim)
R1p   vip   vp    {R1}
R2p   vp    vref  {R2}
R1m   vim   vm    {R1}
R2m   vm    out   {R2}
XU1   vp    vm    out   OP1P

.ac dec 200 1 10Meg
.meas ac gain_1hz FIND mag(V(out)/V(vip,vim)) AT=1
.meas ac gain_1hz_db FIND db(V(out)/V(vip,vim)) AT=1
.meas ac f3db WHEN mag(V(out)/V(vip,vim))=gain_1hz/sqrt(2) FALL=1

.subckt OP1P inp inm out
Eol out 0 LAPLACE {V(inp,inm)} {Aol/(1+s/(2*pi*(GBW/Aol)))}
.ends OP1P

.backanno
.end
