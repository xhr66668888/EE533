* Assignment 5 part d - Wheatstone bridge + instrumentation amplifier transient check
* I use DR=38 here so the no-loading waveform is clearly bigger but still inside 0.5 V to 4.5 V.
* The formal screenshot should use ADA4661-2 op amps in a schematic.

.param R=500 DR=38 R1=25k R2=25k Rfp=45k Rfm=45k RG=10k Aol=1e6 GBW=4Meg

VDD      vdd      0        5
Vdelta   delta_R  0        SINE(0 {DR} 1k)

* Bridge
Rtl      vdd      bplus    {R}
Bbl      bplus    0        I=V(bplus,0)/({R}+V(delta_R))
Btr      vdd      bminus   I=V(vdd,bminus)/({R}+V(delta_R))
Rbr      bminus   0        {R}

* Vref = 2.5 V from divider and unity buffer
Rvtop    vdd      vdiv     100k
Rvbot    vdiv     0        100k
XBUF     vdiv     vref     vref     OP1P

* First instrumentation-amp stage.
* bminus goes to the upper op amp and bplus goes to the lower op amp so final polarity
* matches the difference-amplifier netlist. Swapping them only flips the sine wave.
XU1      bminus   fbp      o1       OP1P
XU2      bplus    fbm      o2       OP1P
Rfp1     o1       fbp      {Rfp}
Rg1      fbp      fbm      {RG}
Rfm1     fbm      o2       {Rfm}

* Output difference stage, gain = R2/R1 = 1
R1m      o1       vm       {R1}
R2m      vm       out      {R2}
R1p      o2       vp       {R1}
R2p      vp       vref     {R2}
XU3      vp       vm       out      OP1P

.tran 0 5m 0 1u
.meas tran bridge_pp PP V(bplus,bminus) FROM=1m TO=5m
.meas tran out_min MIN V(out) FROM=1m TO=5m
.meas tran out_max MAX V(out) FROM=1m TO=5m
.meas tran out_pp PP V(out) FROM=1m TO=5m
.meas tran Isupply AVG (-I(VDD)) FROM=1m TO=5m
.meas tran Ptotal PARAM 5*Isupply

.subckt OP1P inp inm out
Eol out 0 LAPLACE {V(inp,inm)} {Aol/(1+s/(2*pi*(GBW/Aol)))}
.ends OP1P

.backanno
.end
