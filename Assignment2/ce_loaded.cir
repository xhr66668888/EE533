* Common-emitter amplifier (with R_S and R_L for 1% attenuation each)
Vcc   vcc  0   5
Vs    vs   0   DC 0.69 AC 1 SIN(0.69 500u 10)
Rs    vs   vb  20.02
Q1    vc   vb  0   QMOD
Rc    vcc  vc  1k
Cl    vc   0   100n
Rl    vc   0   95.27k
.model QMOD NPN(Is=1e-14 Bf=300 Vaf=100)
.op
.ac dec 100 1 1Meg
.backanno
.end
