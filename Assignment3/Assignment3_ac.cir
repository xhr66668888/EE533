* Assignment 3: MOS common-source + BJT emitter follower, AC response
Vin vin 0 DC 0.9 AC 1
Vdd vdd 0 DC 5
Rd vdd v1 5k
M1 v1 vin 0 0 nmos L=1u W=100u
Q1 vdd v1 vout MAT02
Re vout 0 2k
Cl vout 0 1u
.lib level1_mos.cir
.model MAT02 NPN(IS=0.6p BF=500 VAF=150)
.ac dec 100 1 1Meg
.meas ac gain10_mag FIND mag(V(vout)) AT=10
.meas ac f3db WHEN mag(V(vout))=gain10_mag/sqrt(2) FALL=1
.backanno
.end
